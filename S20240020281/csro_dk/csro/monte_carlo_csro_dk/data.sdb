ADE simulation setup
Run mode: Monte Carlo Sampling
Tests:
  csro_dk:csro:1: csro_dk/csro/schematic, simulator spectre
Global variables:
  Vctrl = 1.8
Corners (all switched off):
  model folders: /home/install/FOUNDRY/analog/180nm/models/spectre
  C0: temperature=0,20,80; Vctrl=1.78,1.8,1.82; gpdk.scs[FF]
  C1: temperature=0,20,80; Vctrl=1.78,1.8,1.82; gpdk.scs[FS]
  C2: temperature=0,20,80; Vctrl=1.78,1.8,1.82; gpdk.scs[NN]
  C3: temperature=0,20,80; Vctrl=1.78,1.8,1.82; gpdk.scs[SF]
  C4: temperature=0,20,80; Vctrl=1.78,1.8,1.82; gpdk.scs[SS]
Monte Carlo Sampling options: mcmethod=all, mcnumpoints=200, parasiticanalysis=0
