ADE simulation setup
Run mode: Single Run, Sweeps and Corners
Tests:
  csro_dk_csro_1: csro_dk/csro/schematic, simulator spectre
    Variables: Vctrl = {Inclusion List}100m{Inclusion List}{From/To}Auto:0.5:27:1.8{From/To}
