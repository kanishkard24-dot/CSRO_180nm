ADE simulation setup
Run mode: Single Run, Sweeps and Corners
Tests:
  csro_dk:csro:1: csro_dk/csro/schematic, simulator spectre
Global variables:
  Vctrl = 1.8
Corners:
  model folders: /home/install/FOUNDRY/analog/180nm/models/spectre
  C0: gpdk.scs[FF]
  C1: gpdk.scs[FS]
  C2: gpdk.scs[NN]
  C3: gpdk.scs[SF]
  C4: gpdk.scs[SS]
