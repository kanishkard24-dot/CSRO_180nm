ADE simulation setup
Test csro_dk_csro_1: csro_dk/csro/schematic, simulator spectre
  Models: /home/install/FOUNDRY/analog/180nm/models/spectre/gpdk.scs[stat]
  Variables: Vctrl = 1.8
  Temperature: 27
  Initial conditions: /Vosc = 0.1
  Analysis tran: stop=2u errpreset=moderate
  Output frequency = frequency(VT("/Vosc"))
  Output average(getData(":pwr" ?result "tran"))
  Output ymax(VT("/Vosc"))
  Signals: /Vosc as Vout
